.subckt nsnrlatch_x1 vdd vss nset nrst q nq
Mnset_nmos q nset _net0 vss sky130_fd_pr__nfet_01v8__model l=1.5e-07 w=1.415e-06
Mnset_pmos vdd nset q vdd sky130_fd_pr__pfet_01v8__model l=1.5e-07 w=1.775e-06
Mnq_nmos _net0 nq vss vss sky130_fd_pr__nfet_01v8__model l=1.5e-07 w=1.415e-06
Mnq_pmos q nq vdd vdd sky130_fd_pr__pfet_01v8__model l=1.5e-07 w=1.775e-06
Mq_nmos vss q _net1 vss sky130_fd_pr__nfet_01v8__model l=1.5e-07 w=1.415e-06
Mq_pmos vdd q nq vdd sky130_fd_pr__pfet_01v8__model l=1.5e-07 w=1.775e-06
Mnrst_nmos _net1 nrst nq vss sky130_fd_pr__nfet_01v8__model l=1.5e-07 w=1.415e-06
Mnrst_pmos nq nrst vdd vdd sky130_fd_pr__pfet_01v8__model l=1.5e-07 w=1.775e-06
.ends nsnrlatch_x1
