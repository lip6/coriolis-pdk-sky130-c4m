.subckt mux2_x1 vdd vss i0 i1 cmd q
Mcmd_inv_nmos cmd_n cmd vss vss sky130_fd_pr__nfet_01v8__model l=1.5e-07 w=8.4e-07
Mcmd_inv_pmos cmd_n cmd vdd vdd sky130_fd_pr__pfet_01v8__model l=1.5e-07 w=8.4e-07
Mi0_nmos vss i0 _net0 vss sky130_fd_pr__nfet_01v8__model l=1.5e-07 w=8.4e-07
Mi0_pmos vdd i0 _net1 vdd sky130_fd_pr__pfet_01v8__model l=1.5e-07 w=8.4e-07
Mcmd_n_npass _net0 cmd_n _q_n vss sky130_fd_pr__nfet_01v8__model l=1.5e-07 w=8.4e-07
Mcmd_ppass _net1 cmd _q_n vdd sky130_fd_pr__pfet_01v8__model l=1.5e-07 w=8.4e-07
Mcmd_npass _q_n cmd _net2 vss sky130_fd_pr__nfet_01v8__model l=1.5e-07 w=8.4e-07
Mcmd_n_ppass _q_n cmd_n _net3 vdd sky130_fd_pr__pfet_01v8__model l=1.5e-07 w=8.4e-07
Mi1_nmos _net2 i1 vss vss sky130_fd_pr__nfet_01v8__model l=1.5e-07 w=8.4e-07
Mi1_pmos _net3 i1 vdd vdd sky130_fd_pr__pfet_01v8__model l=1.5e-07 w=8.4e-07
Mq_n_inv_nmos vss _q_n q vss sky130_fd_pr__nfet_01v8__model l=1.5e-07 w=1.145e-06
Mq_n_inv_pmos vdd _q_n q vdd sky130_fd_pr__pfet_01v8__model l=1.5e-07 w=1.505e-06
.ends mux2_x1
