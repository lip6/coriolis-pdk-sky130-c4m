.subckt or2_x1 vdd vss q i0 i1
Mi0_nmos vss i0 nq vss sky130_fd_pr__nfet_01v8__model l=1.5e-07 w=8.4e-07
Mi0_pmos nq i0 _net0 vdd sky130_fd_pr__pfet_01v8__model l=1.5e-07 w=8.4e-07
Mi1_nmos nq i1 vss vss sky130_fd_pr__nfet_01v8__model l=1.5e-07 w=8.4e-07
Mi1_pmos _net0 i1 vdd vdd sky130_fd_pr__pfet_01v8__model l=1.5e-07 w=8.4e-07
Mn_pd vss nq q vss sky130_fd_pr__nfet_01v8__model l=1.5e-07 w=1.685e-06
Mq_pu vdd nq q vdd sky130_fd_pr__pfet_01v8__model l=1.5e-07 w=2.045e-06
.ends or2_x1
